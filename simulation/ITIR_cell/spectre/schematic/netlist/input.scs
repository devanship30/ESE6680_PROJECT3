// Design: SEMICONDUCTOR_MEMORY/ITIR_cell
simulator lang=spectre
global 0
include "/apps/design_kits/ncsu-cdk-1.6.0.beta/models/spectre/nom/ami06N.m"
include "/apps/design_kits/ncsu-cdk-1.6.0.beta/models/spectre/nom/ami06P.m"

// SEMICONDUCTOR_MEMORY/ITIR_cell/schematic
I0 (BL net6) rram_cell Ron=1000 Roff=100000 D=1e-08 uv=1e-14 p=10 x0=0.5
N0 (net6 WL SL 0) ami06N w=1.5u l=600n m=1 region=sat
V0 (WL 0) vsource type=pulse val0=0 val1=1.8 period=100n rise=100p fall=100p width=50n
V2 (SL 0) vsource type=dc dc=0
V1 (BL 0) vsource type=dc dc=1.5
simulatorOptions options temp=27
tran tran stop=10u
ahdl_include "/lcars/home/p/patel5/cadenceAMI/SEMICONDUCTOR_MEMORY/rram_cell/veriloga/veriloga.va"
