// Design: ESE_6680/project_1_test_optimized
simulator lang=spectre
global 0
parameters Cc=1.1p Rc=4.15K Vdd=4 Ibias=40u L1_2=3u L3_4=3u L5=1.75u L6=1.625u L7=3u L8=3u Vcm=2.5 W1_2=115u W3_4=16.5u W5=37u W6=60u W7=0.000268 W8=44u
include "/lcars/home/e/ese6680/ami06.scs"

// ESE_6680/project_1_optimized/schematic
subckt project_1_optimized Gnd Output Vdd Vin\+ Vin\-
    M6 (Output net55 Gnd Gnd) ami06N w=W6 l=L6 m=1 region=sat
    M3 (net49 net49 Gnd Gnd) ami06N w=W3_4 l=L3_4 m=1 region=sat
    M4 (net55 net49 Gnd Gnd) ami06N w=W3_4 l=L3_4 m=1 region=sat
    Rc (net55 net59) resistor r=Rc m=1
    Cc (net59 Output) capacitor c=Cc m=1
    M7 (Output net48 Vdd Vdd) ami06P w=W7 l=L7 m=1 region=sat
    M8 (net48 net48 Vdd Vdd) ami06P w=W8 l=L8 m=1 region=sat
    M5 (net52 net48 Vdd Vdd) ami06P w=W5 l=L5 m=1 region=sat
    M1 (net49 Vin\- net52 net52) ami06P w=W1_2 l=L1_2 m=1 region=sat
    M2 (net55 Vin\+ net52 net52) ami06P w=W1_2 l=L1_2 m=1 region=sat
    I13 (net48 Gnd) isource type=dc dc=Ibias m=1
ends project_1_optimized

// ESE_6680/project_1_test_optimized/schematic
C3 (Output1 0) capacitor c=2p m=1
C5 (Output3 0) capacitor c=2p m=1
C2 (Output4 0) capacitor c=2p m=1
C4 (Output2 0) capacitor c=2p m=1
V12 (net15 0) vsource type=dc dc=Vdd
V17 (net22 0) vsource type=dc dc=Vdd
V11 (net16 0) vsource type=dc dc=2.5 mag=500m
V10 (net29 0) vsource type=dc dc=2.5 mag=-500m
V14 (net27 0) vsource type=dc dc=2.5 mag=500m
V13 (net24 0) vsource type=dc dc=2.5 mag=500m
V16 (net21 0) vsource type=dc dc=Vdd
V15 (net14 0) vsource type=dc dc=Vdd
V8 (net23 0) vsource type=dc dc=Vcm mag=500m
V7 (net28 0) vsource type=dc dc=Vcm mag=-500m
V0 (net17 0) vsource type=pulse dc=2.5 mag=500m val0=0 val1=5 period=20u rise=1p fall=1p width=10u
I1 (0 Output1 net15 net16 net29) project_1_optimized
I4 (0 Output4 net21 net23 net28) project_1_optimized
I3 (0 Output2 net14 net17 Output2) project_1_optimized
I2 (0 Output3 net22 net24 net27) project_1_optimized
simulatorOptions options temp=27
dcOp dc
save V12:p
