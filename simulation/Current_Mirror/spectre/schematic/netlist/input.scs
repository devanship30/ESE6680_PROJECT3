// Design: ESE_6680/Current_Mirror
simulator lang=spectre
global 0
include "/lcars/home/e/ese6680/ami06.scs"

// ESE_6680/Current_Mirror/schematic
R0 (net07 out) resistor r=74.17K m=1
V0 (net07 0) vsource type=dc dc=4
M9 (out out 0 0) ami06N w=7.95u l=7.95u m=1 region=sat
M10 (out out 0 0) ami06N w=24.0u l=1.5u m=1 region=sat
simulatorOptions options temp=27
dcOp dc
