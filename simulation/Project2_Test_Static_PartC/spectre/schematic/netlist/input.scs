// Design: ese6680/Project2_Test_Static_PartC
simulator lang=spectre
global 0
parameters Vd=0
include "/lcars/home/e/ese6680/ami06.scs"

// ese6680/Project2_StaticComparator/schematic
subckt Project2_StaticComparator Gnd STROBE Vdd Vi1 Vi2 Vo1 Vo2
    P3 (Vo2 STROBE Vo1 Vdd) ami06P w=3u l=600n m=1 region=sat
    P2 (Vo1 STROBE Vo2 Vdd) ami06P w=3u l=600n m=1 region=sat
    P1 (Vo2 Vo1 Vdd Vdd) ami06P w=12.0u l=600n m=1 region=sat
    P0 (Vo1 Vo2 Vdd Vdd) ami06P w=12.0u l=600n m=1 region=sat
    N1 (Vo1 Vi2 net15 Gnd) ami06N w=12.0u l=600n m=1 region=sat
    N0 (Vo2 Vi1 net15 Gnd) ami06N w=12.0u l=600n m=1 region=sat
    I0 (net15 Gnd) isource type=dc dc=30u m=1
ends Project2_StaticComparator

// ese6680/Project2_Test_Static_PartC/schematic
V3 (net2 0) vsource type=dc dc=5
V0 (net1 0) vsource type=dc dc=5
V2 (net3 0) vsource type=dc dc=2.5 - Vd/2
V1 (net4 0) vsource type=dc dc=2.5 + Vd/2
I7 (0 net2 net1 net4 net3 Vo1 Vo2) Project2_StaticComparator
simulatorOptions options temp=27
dc dc hysteresis=yes param=Vd start=-5 stop=5 step=10m
