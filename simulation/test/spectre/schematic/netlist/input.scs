// Design: ESE_6680/test
simulator lang=spectre
global 0
parameters Cf=1.35p Ch=1.35p
include "/lcars/home/e/ese6680/ami06.scs"

// ESE_6680/opamp_project_1/schematic
subckt opamp_project_1 Gnd Output Vdd Vin\+ Vin\-
    M6 (Output net55 Gnd Gnd) ami06N w=60u l=1.65u m=1 region=sat
    M3 (net49 net49 Gnd Gnd) ami06N w=16.5u l=3u m=1 region=sat
    M4 (net55 net49 Gnd Gnd) ami06N w=16.5u l=3u m=1 region=sat
    Rc (net55 net59) resistor r=4.15K m=1
    Cc (net59 Output) capacitor c=1.1p m=1
    M7 (Output net48 Vdd Vdd) ami06P w=268.05u l=3u m=1 region=sat
    M8 (net48 net48 Vdd Vdd) ami06P w=43.95u l=3u m=1 region=sat
    M5 (net52 net48 Vdd Vdd) ami06P w=37.05u l=1.8u m=1 region=sat
    M1 (net49 Vin\- net52 net52) ami06P w=115.05u l=3u m=1 region=sat
    M2 (net55 Vin\+ net52 net52) ami06P w=115.05u l=3u m=1 region=sat
    I13 (net48 Gnd) isource type=dc dc=40u m=1
ends opamp_project_1

// ESE_6680/test/schematic
V0 (VDD 0) vsource type=dc dc=5
V15 (net09 0) vsource type=dc dc=2.5
V12 (net1 0) vsource type=dc dc=2.5
W6 (net2 net09 CLK2 0) relay ropen=1T rclosed=1.0
W5 (net5 Output CLK1 0) relay ropen=1T rclosed=1.0
W3 (Vin net2 CLK1 0) relay ropen=1T rclosed=1.0
C9 (Output 0) capacitor c=1p m=1
C6 (net2 net5) capacitor c=Ch m=1
C5 (net5 Output) capacitor c=Cf m=1
V2 (Vin 0) vsource type=sine sinedc=2.5 ampl=1.5 freq=500K
I38 (0 Output VDD net1 net5) opamp_project_1
V10 (CLK1 0) vsource type=pulse dc=2.5 val0=0 val1=5 period=200n delay=0 rise=200.0p fall=200.0p width=90n
V11 (CLK2 0) vsource type=pulse dc=2.5 val0=0 val1=5 period=200n delay=100n rise=200.0p fall=200.0p width=90n
simulatorOptions options temp=27
tran tran stop=10u
