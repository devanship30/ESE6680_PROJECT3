// Design: ese6680/Test_Opamp_Hw3_SlewRate
simulator lang=spectre
global 0
parameters Cc=1p w=40u
include "/lcars/home/e/ese6680/ami06.scs"

// ese6680/hw3_2stage_opamp/schematic
subckt hw3_2stage_opamp GND VDD Vin\+ Vin\- Vout
    M2 (net11 Vin\+ net09 VDD) ami06P w=109.95u l=3u m=1 region=sat
    M1 (net3 Vin\- net09 VDD) ami06P w=109.95u l=3u m=1 region=sat
    M7 (Vout net019 VDD VDD) ami06P w=268.05u l=2.4u m=1 region=sat
    M5 (net09 net019 VDD VDD) ami06P w=36.0u l=1.2u m=1 region=sat
    M8 (net019 net019 VDD VDD) ami06P w=40.05u l=1.2u m=1 region=sat
    M6 (Vout net11 GND GND) ami06N w=55.05u l=1.8u m=1 region=sat
    M4 (net11 net3 GND GND) ami06N w=17.55u l=3u m=1 region=sat
    M3 (net3 net3 GND GND) ami06N w=17.55u l=3u m=1 region=sat
    C1 (net22 Vout) capacitor c=1.3p m=1
    C0 (Vout GND) capacitor c=2p m=1
    RC (net11 net22) resistor r=2K m=1
    I0 (net019 GND) isource type=dc dc=60u m=1
ends hw3_2stage_opamp

// ese6680/Test_Opamp_Hw3_SlewRate/schematic
V1 (net3 0) vsource type=dc dc=5
I0 (0 net3 net1 net02 net02) hw3_2stage_opamp
V0 (net1 0) vsource type=pulse val0=0 val1=5 period=20u delay=0 rise=1n fall=1n width=10u
simulatorOptions options temp=27
tran tran stop=100u errpreset=conservative
save net02 net1
