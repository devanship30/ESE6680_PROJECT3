// Design: ESE_6680/project_2_flip_around
simulator lang=spectre
global 0
parameters W11=1u W12=1u W13=1u W14=1u W15=1u W16=1u W17=1u W18=1u W9=5u W10=15u Rc=4.15K W7=0.000268 W1_2=115u W6=60u W8=44u Ibias=40u W5=37u W3_4=16.5u L1_2=3u L3_4=3u L7=3u L8=3u L5=1.75u L6=1.625u t=200n Cc=3p Ch=1p
include "/lcars/home/e/ese6680/ami06.scs"

// ESE_6680/project_1_optimized/schematic
subckt project_1_optimized Gnd Output Vdd Vin\+ Vin\-
    M6 (Output net55 Gnd Gnd) ami06N w=W6 l=L6 m=1 region=sat
    M3 (net49 net49 Gnd Gnd) ami06N w=W3_4 l=L3_4 m=1 region=sat
    M4 (net55 net49 Gnd Gnd) ami06N w=W3_4 l=L3_4 m=1 region=sat
    Rc (net55 net59) resistor r=Rc m=1
    Cc (net59 Output) capacitor c=Cc m=1
    M7 (Output net48 Vdd Vdd) ami06P w=W7 l=L7 m=1 region=sat
    M8 (net48 net48 Vdd Vdd) ami06P w=W8 l=L8 m=1 region=sat
    M5 (net52 net48 Vdd Vdd) ami06P w=W5 l=L5 m=1 region=sat
    M1 (net49 Vin\- net52 net52) ami06P w=W1_2 l=L1_2 m=1 region=sat
    M2 (net55 Vin\+ net52 net52) ami06P w=W1_2 l=L1_2 m=1 region=sat
    I13 (net48 Gnd) isource type=dc dc=Ibias m=1
ends project_1_optimized

// ESE_6680/project_2_flip_around/schematic
V1 (net2 0) vsource type=dc dc=2.5
V2 (VDD 0) vsource type=dc dc=5
V0 (net14 0) vsource type=dc dc=2.5
N4 (net7 CLK1 Output 0) ami06N w=W17 l=600n m=1 region=sat
N2 (net3 CLK2 net7 0) ami06N w=W15 l=600n m=1 region=sat
N1 (net2 CLK1\' net3 0) ami06N w=W13 l=600n m=1 region=sat
N0 (net6 CLK2 Output 0) ami06N w=W11 l=600n m=1 region=sat
N3 (Vin CLK1 net6 0) ami06N w=W9 l=600n m=1 region=sat
P4 (Output CLK2 net7 VDD) ami06P w=W18 l=600n m=1 region=sat
P2 (net7 CLK1 net3 VDD) ami06P w=W16 l=600n m=1 region=sat
P1 (net3 CLK2\' net2 VDD) ami06P w=W14 l=600n m=1 region=sat
P0 (Output CLK1 net6 VDD) ami06P w=W12 l=600n m=1 region=sat
P3 (net6 CLK2 Vin VDD) ami06P w=W10 l=600n m=1 region=sat
C2 (net6 net3) capacitor c=Ch m=1
C3 (Output 0) capacitor c=1p m=1
V6 (Vin 0) vsource type=sine sinedc=2.5 ampl=1.5 freq=500K
I6 (0 Output VDD net14 net7) project_1_optimized
V7 (CLK2\' 0) vsource type=pulse dc=2.5 val0=0 val1=5 period=t delay=t/2 rise=1p fall=1p width=(t/2)-15n
V5 (CLK1\' 0) vsource type=pulse dc=2.5 val0=0 val1=5 period=t delay=0 rise=1p fall=1p width=(t/2)-15n
V10 (CLK1 0) vsource type=pulse dc=2.5 val0=0 val1=5 period=t delay=0 rise=1p fall=1p width=(t/2)-10n
V11 (CLK2 0) vsource type=pulse dc=2.5 val0=0 val1=5 period=t delay=t/2 rise=1p fall=1p width=(t/2)-10n
simulatorOptions options temp=27
tran tran stop=10u
