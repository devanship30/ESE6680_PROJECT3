// Design: ESE6680_PROJECT3/mdac_test
simulator lang=spectre
global 0
include "/lcars/home/e/ese6680/ami06.scs"

// ESE6680_PROJECT3/opamp_project_1/schematic
subckt opamp_project_1 Gnd Output Vdd Vin\+ Vin\-
    M6 (Output net55 Gnd Gnd) ami06N w=60u l=1.65u m=1 region=sat
    M3 (net49 net49 Gnd Gnd) ami06N w=16.5u l=3u m=1 region=sat
    M4 (net55 net49 Gnd Gnd) ami06N w=16.5u l=3u m=1 region=sat
    Rc (net55 net59) resistor r=4.15K m=1
    Cc (net59 Output) capacitor c=1.1p m=1
    M7 (Output net48 Vdd Vdd) ami06P w=268.05u l=3u m=1 region=sat
    M8 (net48 net48 Vdd Vdd) ami06P w=43.95u l=3u m=1 region=sat
    M5 (net52 net48 Vdd Vdd) ami06P w=37.05u l=1.8u m=1 region=sat
    M1 (net49 Vin\- net52 net52) ami06P w=115.05u l=3u m=1 region=sat
    M2 (net55 Vin\+ net52 net52) ami06P w=115.05u l=3u m=1 region=sat
    I13 (net48 Gnd) isource type=dc dc=40u m=1
ends opamp_project_1

// ESE6680_PROJECT3/Final_MDAC/schematic
subckt Final_MDAC GND Phi1 Phi1E Phi2 VDD Vin\+ Vin\- Vout
    Cf (Cf_top net5) cap
    Cs (Cs_top net5) cap
    N10 (Cs_top Phi1 Vin\+ GND) ami06P w=1.5u l=600n m=1 region=sat
    N9 (Cf_top Phi1 Vin\+ GND) ami06P w=1.5u l=600n m=1 region=sat
    N8 (Cs_top Phi2 Vin\- GND) ami06P w=1.5u l=600n m=1 region=sat
    N7 (\2\.5V Phi2 Vout GND) ami06P w=1.5u l=600n m=1 region=sat
    N6 (Cf_top Phi1 Vout GND) ami06P w=1.5u l=600n m=1 region=sat
    N1 (Phi2\' Phi2 GND GND) ami06N w=1.5u l=600n m=1 region=sat
    N0 (Phi1\' Phi1 GND GND) ami06N w=1.5u l=600n m=1 region=sat
    I1 (GND Vout VDD \2\.5V net5) opamp_project_1
    P12 (Cs_top Phi1\' Vin\+ VDD) ami06P w=1.5u l=600n m=1 region=sat
    P11 (Cf_top Phi1\' Vin\+ VDD) ami06P w=1.5u l=600n m=1 region=sat
    P10 (Cs_top Phi2\' Vin\- VDD) ami06P w=1.5u l=600n m=1 region=sat
    P9 (\2\.5V Phi2\' Vout VDD) ami06P w=1.5u l=600n m=1 region=sat
    P8 (Cf_top Phi1\' Vout VDD) ami06P w=1.5u l=600n m=1 region=sat
    P1 (Phi2\' Phi2 VDD VDD) ami06P w=1.5u l=600n m=1 region=sat
    P0 (Phi1\' Phi1 VDD VDD) ami06P w=1.5u l=600n m=1 region=sat
    V0 (\2\.5V 0) vsource dc=2.5 type=dc
ends Final_MDAC

// ESE6680_PROJECT3/mdac_test/schematic
I0 (0 Phi1 Phi1E Phi2 VDD Vin\+ Vin\- Vout) Final_MDAC
V2 (Vin\- 0) vsource dc=2.5 type=dc
V0 (VDD 0) vsource dc=5 type=dc
V5 (Phi2 0) vsource type=pulse val0=0 val1=5 period=200n delay=110n rise=10p fall=10p width=80n
V4 (Phi1E 0) vsource type=pulse val0=0 val1=5 period=200n rise=10p fall=10p width=80n
V3 (Phi1 0) vsource type=pulse val0=0 val1=5 period=200n rise=10p fall=10p width=90n
V6 (Vin\+ 0) vsource type=pulse val0=2 val1=3 period=1u rise=1n fall=1n width=500n
simulatorOptions options temp=27
tran tran stop=5u
ahdl_include "/lcars/software/linux/x86_64/ic-design/cadence/IC618/tools/dfII/samples/artist/ahdlLib/cap/veriloga/veriloga.va"
