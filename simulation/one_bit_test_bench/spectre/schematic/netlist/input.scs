// Design: ESE6680_PROJECT3/one_bit_test_bench
simulator lang=spectre
global 0
include "/lcars/home/e/ese6680/ami06.scs"

// ESE6680_PROJECT3/inv/schematic
subckt inv IN OUT VDD
    N0 (OUT IN 0 0) ami06N w=1.5u l=600n m=1 region=sat
    P0 (OUT IN VDD VDD) ami06P w=3u l=600n m=1 region=sat
ends inv

// ESE6680_PROJECT3/nand/schematic
subckt nand A B OUT VDD
    N1 (net9 B 0 0) ami06N w=1.5u l=600n m=1 region=sat
    N0 (OUT A net9 0) ami06N w=1.5u l=600n m=1 region=sat
    P1 (OUT B VDD VDD) ami06P w=3u l=600n m=1 region=sat
    P0 (OUT A VDD VDD) ami06P w=3u l=600n m=1 region=sat
ends nand

// ESE6680_PROJECT3/non_overlapping_clock/schematic
subckt non_overlapping_clock CLK Phi1 Phi1E Phi2 VDD
    I193 (net027 Phi2 VDD) inv
    I192 (net030 Phi1 VDD) inv
    I175 (net024 net035 VDD) inv
    I189 (net028 net029 VDD) inv
    I29 (net035 Phi1E VDD) inv
    I17 (net010 net024 VDD) inv
    I28 (net029 net022 VDD) inv
    I14 (CLK net049 VDD) inv
    I155 (net017 net028 VDD) inv
    I83 (net022 net010 net027 VDD) nand
    I82 (Phi1E net017 net030 VDD) nand
    I15 (CLK net017 net010 VDD) nand
    I16 (net049 net010 net017 VDD) nand
ends non_overlapping_clock

// ESE6680_PROJECT3/Final_StaticComparator/schematic
subckt Final_StaticComparator Gnd STROBE Vdd Vi1 Vi2 Vo1 Vo2
    I0 (net58 Gnd) isource type=dc dc=30u m=1
    N1 (Vo1 Vi2 net58 Gnd) ami06N w=12.0u l=600n m=1 region=sat
    N0 (Vo2 Vi1 net58 Gnd) ami06N w=12.0u l=600n m=1 region=sat
    P1 (Vo2 Vo1 Vdd Vdd) ami06P w=12.0u l=600n m=1 region=sat
    P0 (Vo1 Vo2 Vdd Vdd) ami06P w=12.0u l=600n m=1 region=sat
    P2 (Vo1 STROBE Vo2 Vdd) ami06P w=3u l=600n m=1 region=sat
    P3 (Vo2 STROBE Vo1 Vdd) ami06P w=3u l=600n m=1 region=sat
ends Final_StaticComparator

// ESE6680_PROJECT3/Vref_gen/schematic
subckt Vref_gen GND VC VC\' VDD VREF
    R3 (\3\.25V GND) resistor r=3.25K
    R2 (VDD \3\.25V) resistor r=1.75K
    R1 (\1\.75V GND) resistor r=1.75K
    R0 (VDD \1\.75V) resistor r=3.25K
    N1 (VREF VC\' \1\.75V GND) ami06N w=1.5u l=600n m=1 region=sat
    N0 (VREF VC \3\.25V GND) ami06N w=1.5u l=600n m=1 region=sat
    P1 (VREF VC\' \3\.25V VDD) ami06P w=1.5u l=600n m=1 region=sat
    P0 (VREF VC \1\.75V VDD) ami06P w=1.5u l=600n m=1 region=sat
ends Vref_gen

// ESE6680_PROJECT3/m_opamp/schematic
subckt m_opamp GND VDD Vin\+ Vin\- Vout
    M4 (net77 net74 GND GND) ami06N w=8.7u l=1.8u m=1 region=sat
    M3 (net74 net74 GND GND) ami06N w=8.7u l=1.8u m=1 region=sat
    M6 (Vout net77 GND GND) ami06N w=58.05u l=900n m=1 region=sat
    M7 (Vout net73 VDD VDD) ami06P w=133.95u l=1.2u m=1 region=sat
    M5 (net81 net73 VDD VDD) ami06P w=40.05u l=1.2u m=1 region=sat
    M8 (net73 net73 VDD VDD) ami06P w=40.05u l=1.2u m=1 region=sat
    M2 (net77 Vin\+ net81 VDD) ami06P w=49.95u l=1.8u m=1 region=sat
    M1 (net74 Vin\- net81 VDD) ami06P w=49.95u l=1.8u m=1 region=sat
    Iref (net73 GND) isource type=dc dc=60u m=1
    Cc (net84 Vout) capacitor c=1p m=1
    Rc (net77 net84) resistor r=1K m=1
ends m_opamp

// ESE6680_PROJECT3/Final_MDAC/schematic
subckt Final_MDAC GND Phi1 Phi1E Phi2 VDD Vin\+ Vin\- Vout
    N2 (Vout Phi2 net100 GND) ami06N w=1.5u l=600n m=1 region=sat
    N1 (net102 Phi1 net100 GND) ami06N w=1.5u l=600n m=1 region=sat
    N0 (net99 Phi1E net107 GND) ami06N w=1.5u l=600n m=1 region=sat
    N3 (Vin\+ Phi2 net97 GND) ami06N w=1.5u l=600n m=1 region=sat
    N4 (net97 Phi1 Vin\- GND) ami06N w=1.5u l=600n m=1 region=sat
    N6 (iPhi2 Phi2 GND GND) ami06N w=1.5u l=600n m=1 region=sat
    N5 (iPhi1 Phi1 GND GND) ami06N w=1.5u l=600n m=1 region=sat
    P1 (Vout iPhi2 net100 VDD) ami06P w=1.5u l=600n m=1 region=sat
    P2 (net102 iPhi1 net100 VDD) ami06P w=1.5u l=600n m=1 region=sat
    P0 (net97 iPhi1 Vin\- VDD) ami06P w=1.5u l=600n m=1 region=sat
    P3 (Vin\+ iPhi2 net97 VDD) ami06P w=1.5u l=600n m=1 region=sat
    P5 (iPhi2 Phi2 VDD VDD) ami06P w=1.5u l=600n m=1 region=sat
    P4 (iPhi1 Phi1 VDD VDD) ami06P w=1.5u l=600n m=1 region=sat
    Cf (net99 net100) capacitor c=1p m=1
    Cs (net97 net99) capacitor c=2p m=1
    V2 (net102 GND) vsource type=dc dc=2.5
    V0 (net106 GND) vsource type=dc dc=2.5
    V1 (net107 GND) vsource type=dc dc=2.5
    I0 (GND VDD net106 net99 Vout) m_opamp
ends Final_MDAC

// ESE6680_PROJECT3/BOOT_THA/schematic
subckt BOOT_THA CLKS GND VDD VIN VOUT
    N7 (GND CLKS_ VY GND) ami06N w=1.5u l=600n m=1 region=sat
    N6 (VY VDD VG GND) ami06N w=1.5u l=600n m=1 region=sat
    N5 (CLKS_ CLKS GND GND) ami06N w=1.5u l=600n m=1 region=sat
    N4 (VBOTT CLKS_ GND GND) ami06N w=1.5u l=600n m=1 region=sat
    N3 (VOUT VG VIN GND) ami06N w=1.5u l=600n m=1 region=sat
    N2 (VIN VG VBOTT GND) ami06N w=1.5u l=600n m=1 region=sat
    N1 (VBOTT VG VX GND) ami06N w=1.5u l=600n m=1 region=sat
    N0 (VX CLKS VBOTT GND) ami06N w=1.5u l=600n m=1 region=sat
    P4 (VOUT CLKS_ VIN VDD) ami06P w=1.5u l=600n m=1 region=sat
    P3 (VG VX VTOP VTOP) ami06P w=1.5u l=600n m=1 region=sat
    P2 (VDD VG VTOP VTOP) ami06P w=1.5u l=600n m=1 region=sat
    P1 (VX CLKS VDD VDD) ami06P w=1.5u l=600n m=1 region=sat
    P0 (CLKS_ CLKS VDD VDD) ami06P w=1.5u l=600n m=1 region=sat
    C1 (VOUT GND) capacitor c=1p
    C0 (VTOP VBOTT) capacitor c=1p
ends BOOT_THA

// ESE6680_PROJECT3/DFF/schematic
subckt DFF CLK D GND Q VDD
    N8 (net21 CLK\' net19 GND) ami06N w=1.5u l=600n m=1 region=sat
    N7 (net19 CLK net18 GND) ami06N w=1.5u l=600n m=1 region=sat
    N6 (net11 CLK net9 GND) ami06N w=1.5u l=600n m=1 region=sat
    N5 (net9 CLK\' D GND) ami06N w=1.5u l=600n m=1 region=sat
    N4 (CLK\' CLK GND GND) ami06N w=1.5u l=600n m=1 region=sat
    N3 (GND Q net21 GND) ami06N w=1.5u l=600n m=1 region=sat
    N2 (Q net19 GND GND) ami06N w=1.5u l=600n m=1 region=sat
    N1 (GND net18 net11 GND) ami06N w=1.5u l=600n m=1 region=sat
    N0 (net18 net9 GND GND) ami06N w=1.5u l=600n m=1 region=sat
    P4 (net21 Q VDD VDD) ami06P w=1.5u l=600n m=1 region=sat
    P3 (VDD net19 Q VDD) ami06P w=1.5u l=600n m=1 region=sat
    P2 (CLK\' CLK VDD VDD) ami06P w=1.5u l=600n m=1 region=sat
    P1 (VDD net18 net11 VDD) ami06P w=1.5u l=600n m=1 region=sat
    P0 (net18 net9 VDD VDD) ami06P w=1.5u l=600n m=1 region=sat
ends DFF

// ESE6680_PROJECT3/one_bit_stage/schematic
subckt one_bit_stage BIT CLKIN GND VDD VIN VOUT
    I0 (CLKIN PHI1 PHI1E PHI2 VDD) non_overlapping_clock
    I1 (GND PHI2 VDD BOOT_VOUT DC Vo1 Vo2) Final_StaticComparator
    I2 (GND Vo1 VC\' VDD VREF) Vref_gen
    I3 (GND PHI1 PHI1E PHI2 VDD BOOT_VOUT VREF VOUT) Final_MDAC
    I4 (PHI1 GND VDD VIN BOOT_VOUT) BOOT_THA
    V0 (DC GND) vsource dc=2.5 type=dc
    I19 (PHI2 Vo2 GND VC\' VDD) DFF
    I16 (CLKIN Vo1 GND BIT VDD) DFF
ends one_bit_stage

// ESE6680_PROJECT3/one_bit_test_bench/schematic
I0 (BIT CLKIN 0 VDD VIN VOUT) one_bit_stage
V0 (VDD 0) vsource dc=5 type=dc
V2 (VIN 0) vsource dc=2.5 type=sine ampl=1.5 freq=1M
V3 (CLKIN 0) vsource type=pulse val0=0 val1=5 period=100n rise=10p fall=10p width=50n
simulatorOptions options temp=27
tran tran stop=5u
