// Design: ESE6680_PROJECT3/one_bit_test_bench
simulator lang=spectre
global 0
include "/lcars/home/e/ese6680/ami06.scs"

// ESE6680_PROJECT3/inv/schematic
subckt inv IN OUT VDD
    N0 (OUT IN 0 0) ami06N w=1.5u l=600n m=1 region=sat
    P0 (OUT IN VDD VDD) ami06P w=3u l=600n m=1 region=sat
ends inv

// ESE6680_PROJECT3/buffer/schematic
subckt buffer IN OUT VDD
    I1 (net5 OUT VDD) inv
    I0 (IN net5 VDD) inv
ends buffer

// ESE6680_PROJECT3/nand/schematic
subckt nand A B OUT VDD
    N1 (net9 B 0 0) ami06N w=1.5u l=600n m=1 region=sat
    N0 (OUT A net9 0) ami06N w=1.5u l=600n m=1 region=sat
    P1 (OUT B VDD VDD) ami06P w=3u l=600n m=1 region=sat
    P0 (OUT A VDD VDD) ami06P w=3u l=600n m=1 region=sat
ends nand

// ESE6680_PROJECT3/non_overlapping_clock/schematic
subckt non_overlapping_clock CLK Phi1 Phi1E Phi2 VDD phi1\' phi2\'
    I221 (net038 phi1\' VDD) buffer
    I220 (net039 net038 VDD) buffer
    I218 (net037 phi2\' VDD) buffer
    I217 (net036 net037 VDD) buffer
    I205 (net26 Phi1 VDD) buffer
    I208 (net22 net23 VDD) buffer
    I203 (net35 net34 VDD) buffer
    I210 (net24 net13 VDD) buffer
    I207 (net21 net22 VDD) buffer
    I206 (net15 net20 VDD) buffer
    I209 (net23 net24 VDD) buffer
    I202 (net33 Phi1E VDD) buffer
    I204 (net27 net26 VDD) buffer
    I201 (net34 net33 VDD) buffer
    I214 (net16 net13 Phi2 VDD) nand
    I213 (net20 net12 net21 VDD) nand
    I198 (net12 net10 net27 VDD) nand
    I197 (CLK net16 net10 VDD) nand
    I219 (Phi1 net039 VDD) inv
    I216 (Phi2 net036 VDD) inv
    I215 (CLK net15 VDD) inv
    I212 (net025 net16 VDD) inv
    I211 (net13 net025 VDD) inv
    I200 (Phi1E net12 VDD) inv
    I199 (net10 net35 VDD) inv
ends non_overlapping_clock

// ESE6680_PROJECT3/Final_StaticComparator/schematic
subckt Final_StaticComparator Gnd STROBE Vdd Vi1 Vi2 Vo1 Vo2
    I0 (net58 Gnd) isource type=dc dc=60u m=1
    P7 (net023 STROBE net09 net029) ami06P w=10.05u l=600n m=1 region=sat
    P6 (net09 STROBE net023 net029) ami06P w=10.05u l=600n m=1 region=sat
    P5 (Vdd net03 Vo2 Vdd) ami06P w=1.5u l=600n m=1 region=sat
    P4 (Vdd net09 net03 Vdd) ami06P w=1.5u l=600n m=1 region=sat
    P3 (Vdd net023 net09 Vdd) ami06P w=1.5u l=600n m=1 region=sat
    P2 (net023 net09 Vdd Vdd) ami06P w=1.5u l=600n m=1 region=sat
    P1 (Vo1 net018 Vdd Vdd) ami06P w=1.5u l=600n m=1 region=sat
    P0 (net018 net023 Vdd Vdd) ami06P w=1.5u l=600n m=1 region=sat
    N5 (Vo1 net018 Gnd Gnd) ami06N w=1.5u l=600n m=1 region=sat
    N4 (net018 net023 Gnd Gnd) ami06N w=1.5u l=600n m=1 region=sat
    N1 (Gnd net09 net03 Gnd) ami06N w=1.5u l=600n m=1 region=sat
    N0 (Gnd net03 Vo2 Gnd) ami06N w=1.5u l=600n m=1 region=sat
    N2 (net09 Vi1 net58 net026) ami06N w=1.5u l=600n m=1 region=sat
    N3 (net58 Vi2 net023 net026) ami06N w=1.5u l=600n m=1 region=sat
ends Final_StaticComparator

// ESE6680_PROJECT3/Vref_gen/schematic
subckt Vref_gen GND VC VC\' VDD VREF
    R3 (\3\.25V GND) resistor r=3.25K
    R2 (VDD \3\.25V) resistor r=1.75K
    R1 (\1\.75V GND) resistor r=1.75K
    R0 (VDD \1\.75V) resistor r=3.25K
    N1 (VREF VC\' \1\.75V GND) ami06N w=1.5u l=600n m=1 region=sat
    N0 (VREF VC \3\.25V GND) ami06N w=1.5u l=600n m=1 region=sat
    P1 (VREF VC\' \3\.25V VDD) ami06P w=1.5u l=600n m=1 region=sat
    P0 (VREF VC \1\.75V VDD) ami06P w=1.5u l=600n m=1 region=sat
ends Vref_gen

// ESE6680_PROJECT3/m_opamp/schematic
subckt m_opamp GND VDD Vin\+ Vin\- Vout
    M4 (net77 net74 GND GND) ami06N w=8.7u l=1.8u m=1 region=sat
    M3 (net74 net74 GND GND) ami06N w=8.7u l=1.8u m=1 region=sat
    M6 (Vout net77 GND GND) ami06N w=58.05u l=900n m=1 region=sat
    M7 (Vout net73 VDD VDD) ami06P w=133.95u l=1.2u m=1 region=sat
    M5 (net81 net73 VDD VDD) ami06P w=40.05u l=1.2u m=1 region=sat
    M8 (net73 net73 VDD VDD) ami06P w=40.05u l=1.2u m=1 region=sat
    M2 (net77 Vin\+ net81 VDD) ami06P w=49.95u l=1.8u m=1 region=sat
    M1 (net74 Vin\- net81 VDD) ami06P w=49.95u l=1.8u m=1 region=sat
    Iref (net73 GND) isource type=dc dc=60u m=1
    Cc (net84 Vout) capacitor c=1p m=1
    Rc (net77 net84) resistor r=1K m=1
ends m_opamp

// ESE6680_PROJECT3/Final_MDAC/schematic
subckt Final_MDAC GND Phi1 Phi1E Phi2 VDD Vin\+ Vin\- Vout
    N2 (Vout Phi2 net100 GND) ami06N w=1.5u l=600n m=1 region=sat
    N1 (net102 Phi1 net100 GND) ami06N w=1.5u l=600n m=1 region=sat
    N0 (net99 Phi1E net107 GND) ami06N w=1.5u l=600n m=1 region=sat
    N3 (Vin\+ Phi2 net97 GND) ami06N w=1.5u l=600n m=1 region=sat
    N4 (net97 Phi1 Vin\- GND) ami06N w=1.5u l=600n m=1 region=sat
    N6 (iPhi2 Phi2 GND GND) ami06N w=1.5u l=600n m=1 region=sat
    N5 (iPhi1 Phi1 GND GND) ami06N w=1.5u l=600n m=1 region=sat
    P1 (Vout iPhi2 net100 VDD) ami06P w=1.5u l=600n m=1 region=sat
    P2 (net102 iPhi1 net100 VDD) ami06P w=1.5u l=600n m=1 region=sat
    P0 (net97 iPhi1 Vin\- VDD) ami06P w=1.5u l=600n m=1 region=sat
    P3 (Vin\+ iPhi2 net97 VDD) ami06P w=1.5u l=600n m=1 region=sat
    P5 (iPhi2 Phi2 VDD VDD) ami06P w=1.5u l=600n m=1 region=sat
    P4 (iPhi1 Phi1 VDD VDD) ami06P w=1.5u l=600n m=1 region=sat
    Cf (net99 net100) capacitor c=1p m=1
    Cs (net97 net99) capacitor c=2p m=1
    V2 (net102 GND) vsource type=dc dc=2.5
    V0 (net106 GND) vsource type=dc dc=2.5
    V1 (net107 GND) vsource type=dc dc=2.5
    I0 (GND VDD net106 net99 Vout) m_opamp
ends Final_MDAC

// ESE6680_PROJECT3/opamp_project_1/schematic
subckt opamp_project_1 Gnd Output Vdd Vin\+ Vin\-
    M6 (Output net55 Gnd Gnd) ami06N w=60u l=1.65u m=1 region=sat
    M3 (net49 net49 Gnd Gnd) ami06N w=16.5u l=3u m=1 region=sat
    M4 (net55 net49 Gnd Gnd) ami06N w=16.5u l=3u m=1 region=sat
    Rc (net55 net59) resistor r=4.15K m=1
    Cc (net59 Output) capacitor c=1.1p m=1
    M7 (Output net48 Vdd Vdd) ami06P w=268.05u l=3u m=1 region=sat
    M8 (net48 net48 Vdd Vdd) ami06P w=43.95u l=3u m=1 region=sat
    M5 (net52 net48 Vdd Vdd) ami06P w=37.05u l=1.8u m=1 region=sat
    M1 (net49 Vin\- net52 net52) ami06P w=115.05u l=3u m=1 region=sat
    M2 (net55 Vin\+ net52 net52) ami06P w=115.05u l=3u m=1 region=sat
    I13 (net48 Gnd) isource type=dc dc=40u m=1
ends opamp_project_1

// ESE6680_PROJECT3/project_2_baseline_design/schematic
subckt project_2_baseline_design Output VDD Vin half_VDD phi1 phi1\' phi2 phi2\'
    N2 (net016 phi1 Output 0) ami06N w=6.45u l=600n m=1 region=sat
    N0 (Vin phi1 net02 0) ami06N w=4.95u l=600n m=1 region=sat
    N1 (net02 phi2 half_VDD 0) ami06N w=3.45u l=600n m=1 region=sat
    C7 (net02 net016) capacitor c=1.35p m=1
    C3 (Output 0) capacitor c=1p m=1
    C8 (net016 Output) capacitor c=1.35p m=1
    I40 (0 Output VDD net05 net016) opamp_project_1
    V9 (net05 0) vsource type=dc dc=2.5
    P2 (net02 phi2\' half_VDD VDD) ami06P w=4.95u l=600n m=1 region=sat
    P0 (Output phi1\' net016 VDD) ami06P w=7.5u l=600n m=1 region=sat
    P1 (net02 phi1\' Vin VDD) ami06P w=45.0u l=600n m=1 region=sat
ends project_2_baseline_design

// ESE6680_PROJECT3/DFF/schematic
subckt DFF CLK D GND Q VDD
    N8 (net21 CLK\' net19 GND) ami06N w=1.5u l=600n m=1 region=sat
    N7 (net19 CLK net18 GND) ami06N w=1.5u l=600n m=1 region=sat
    N6 (net11 CLK net9 GND) ami06N w=1.5u l=600n m=1 region=sat
    N5 (net9 CLK\' D GND) ami06N w=1.5u l=600n m=1 region=sat
    N4 (CLK\' CLK GND GND) ami06N w=1.5u l=600n m=1 region=sat
    N3 (GND Q net21 GND) ami06N w=1.5u l=600n m=1 region=sat
    N2 (Q net19 GND GND) ami06N w=1.5u l=600n m=1 region=sat
    N1 (GND net18 net11 GND) ami06N w=1.5u l=600n m=1 region=sat
    N0 (net18 net9 GND GND) ami06N w=1.5u l=600n m=1 region=sat
    P4 (net21 Q VDD VDD) ami06P w=1.5u l=600n m=1 region=sat
    P3 (VDD net19 Q VDD) ami06P w=1.5u l=600n m=1 region=sat
    P2 (CLK\' CLK VDD VDD) ami06P w=1.5u l=600n m=1 region=sat
    P1 (VDD net18 net11 VDD) ami06P w=1.5u l=600n m=1 region=sat
    P0 (net18 net9 VDD VDD) ami06P w=1.5u l=600n m=1 region=sat
ends DFF

// ESE6680_PROJECT3/one_bit_stage/schematic
subckt one_bit_stage BIT CLKIN GND VDD VIN VOUT
    I0 (CLKIN PHI1 PHI1E PHI2 VDD PHI1\' PHI2\') non_overlapping_clock
    I1 (GND PHI2 VDD THA_VOUT DC Vo1 Vo2) Final_StaticComparator
    I2 (GND BIT Vo2 VDD VREF) Vref_gen
    I3 (GND PHI1 PHI1E PHI2 VDD THA_VOUT VREF VOUT) Final_MDAC
    I4 (THA_VOUT VDD VIN DC PHI1 PHI1\' PHI2 PHI2\') project_2_baseline_design
    V0 (DC GND) vsource dc=2.5 type=dc
    I16 (CLKIN Vo1 GND BIT VDD) DFF
ends one_bit_stage

// ESE6680_PROJECT3/one_bit_test_bench/schematic
I0 (BIT CLKIN 0 VDD VIN VOUT) one_bit_stage
V0 (VDD 0) vsource dc=5 type=dc
V2 (VIN 0) vsource dc=2.5 type=sine ampl=1.5 freq=1M
V3 (CLKIN 0) vsource type=pulse val0=0 val1=5 period=100n rise=5p fall=5p width=50n
simulatorOptions options temp=27
tran tran stop=10u maxstep=5n
