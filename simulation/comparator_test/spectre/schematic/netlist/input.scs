// Design: ESE6680_PROJECT3/comparator_test
simulator lang=spectre
global 0
include "/lcars/home/e/ese6680/ami06.scs"

// ESE6680_PROJECT3/Final_StaticComparator/schematic
subckt Final_StaticComparator Gnd STROBE Vdd Vi1 Vi2 Vo1 Vo2
    I0 (net58 Gnd) isource type=dc dc=60u m=1
    P7 (net023 STROBE net09 net029) ami06P w=10.05u l=600n m=1 region=sat
    P6 (net09 STROBE net023 net029) ami06P w=10.05u l=600n m=1 region=sat
    P5 (Vdd net03 Vo2 Vdd) ami06P w=1.5u l=600n m=1 region=sat
    P4 (Vdd net09 net03 Vdd) ami06P w=1.5u l=600n m=1 region=sat
    P3 (Vdd net023 net09 Vdd) ami06P w=1.5u l=600n m=1 region=sat
    P2 (net023 net09 Vdd Vdd) ami06P w=1.5u l=600n m=1 region=sat
    P1 (Vo1 net018 Vdd Vdd) ami06P w=1.5u l=600n m=1 region=sat
    P0 (net018 net023 Vdd Vdd) ami06P w=1.5u l=600n m=1 region=sat
    N5 (Vo1 net018 Gnd Gnd) ami06N w=1.5u l=600n m=1 region=sat
    N4 (net018 net023 Gnd Gnd) ami06N w=1.5u l=600n m=1 region=sat
    N1 (Gnd net09 net03 Gnd) ami06N w=1.5u l=600n m=1 region=sat
    N0 (Gnd net03 Vo2 Gnd) ami06N w=1.5u l=600n m=1 region=sat
    N2 (net09 Vi1 net58 net026) ami06N w=1.5u l=600n m=1 region=sat
    N3 (net58 Vi2 net023 net026) ami06N w=1.5u l=600n m=1 region=sat
ends Final_StaticComparator

// ESE6680_PROJECT3/comparator_test/schematic
I0 (0 STROBE net3 Vi1 Vi2 Vo1 Vo2) Final_StaticComparator
V2 (Vi2 0) vsource dc=2.5 type=dc
V0 (net3 0) vsource dc=5 type=dc
V1 (Vi1 0) vsource dc=2.5 type=sine ampl=1.5 freq=1M
V3 (STROBE 0) vsource type=pulse val0=5 val1=0 period=200n rise=200p width=100n
simulatorOptions options temp=27
tran tran stop=5u
