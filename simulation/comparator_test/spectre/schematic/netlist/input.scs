// Design: ESE6680_PROJECT3/comparator_test
simulator lang=spectre
global 0
include "/lcars/home/e/ese6680/ami06.scs"

// ESE6680_PROJECT3/Final_StaticComparator/schematic
subckt Final_StaticComparator Gnd STROBE Vdd Vi1 Vi2 Vo1 Vo2
    I0 (net58 Gnd) isource type=dc dc=30u m=1
    N1 (Vo1 Vi2 net58 Gnd) ami06N w=12.0u l=600n m=1 region=sat
    N0 (Vo2 Vi1 net58 Gnd) ami06N w=12.0u l=600n m=1 region=sat
    P1 (Vo2 Vo1 Vdd Vdd) ami06P w=12.0u l=600n m=1 region=sat
    P0 (Vo1 Vo2 Vdd Vdd) ami06P w=12.0u l=600n m=1 region=sat
    P2 (Vo1 STROBE Vo2 Vdd) ami06P w=3u l=600n m=1 region=sat
    P3 (Vo2 STROBE Vo1 Vdd) ami06P w=3u l=600n m=1 region=sat
ends Final_StaticComparator

// ESE6680_PROJECT3/comparator_test/schematic
I0 (0 STROBE net3 Vi1 Vi2 Vo1 Vo2) Final_StaticComparator
V2 (Vi2 0) vsource dc=2.5 type=dc
V0 (net3 0) vsource dc=5 type=dc
V1 (Vi1 0) vsource dc=2.5 type=sine ampl=1.5 freq=1M
V3 (STROBE 0) vsource type=pulse val0=0 val1=5 period=200n rise=10p fall=10p width=100n
simulatorOptions options temp=27
tran tran stop=5u
