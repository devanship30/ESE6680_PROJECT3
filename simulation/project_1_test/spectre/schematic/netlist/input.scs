// Design: ESE_6680/project_1_test
simulator lang=spectre
global 0
parameters Vcm=2.5
include "/lcars/home/e/ese6680/ami06.scs"

// ESE_6680/project_1/schematic
subckt project_1 Gnd Output Vdd Vin\+ Vin\-
    M7 (Output net2 Vdd Vdd) ami06P w=229.95u l=1.2u m=1 region=sat
    M8 (net2 net2 Vdd Vdd) ami06P w=40.05u l=1.2u m=1 region=sat
    M5 (net6 net2 Vdd Vdd) ami06P w=40.05u l=1.2u m=1 region=sat
    M1 (net3 Vin\- net6 net6) ami06P w=49.95u l=900n m=1 region=sat
    M2 (net17 Vin\+ net6 net6) ami06P w=49.95u l=900n m=1 region=sat
    I13 (net2 Gnd) isource type=dc dc=20u m=1
    Rc (net17 net28) resistor r=1K m=1
    Cc (net28 Output) capacitor c=2p m=1
    M6 (Output net17 Gnd Gnd) ami06N w=67.35u l=900n m=1 region=sat
    M3 (net3 net3 Gnd Gnd) ami06N w=8.7u l=900n m=1 region=sat
    M4 (net17 net3 Gnd Gnd) ami06N w=8.7u l=900n m=1 region=sat
ends project_1

// ESE_6680/project_1_test/schematic
I32 (0 Output3 net018 net011 net019) project_1
I30 (0 Output2 net08 net07 Output2) project_1
I24 (0 Output1 net09 net023 net021) project_1
I23 (0 Output4 net017 net06 net016) project_1
V17 (net018 0) vsource type=dc dc=5
V16 (net017 0) vsource type=dc dc=5
V15 (net08 0) vsource type=dc dc=5
V14 (net019 0) vsource type=dc dc=2.5 mag=500m
V13 (net011 0) vsource type=dc dc=2.5 mag=500m
V12 (net09 0) vsource type=dc dc=5
V11 (net023 0) vsource type=dc dc=2.5 mag=500m
V10 (net021 0) vsource type=dc dc=2.5 mag=-500m
V8 (net06 0) vsource type=dc dc=Vcm mag=500m
V7 (net016 0) vsource type=dc dc=Vcm mag=-500m
V0 (net07 0) vsource type=pulse dc=2.5 mag=500m val0=0 val1=5 period=20u rise=1p fall=1p width=10u
C5 (Output3 0) capacitor c=2p m=1
C4 (Output2 0) capacitor c=2p m=1
C3 (Output1 0) capacitor c=2p m=1
C2 (Output4 0) capacitor c=2p m=1
simulatorOptions options temp=27
tran tran stop=100u
