// Design: ESE_6680/Current_Mirror_OPAMP_Test
simulator lang=spectre
global 0
parameters Cc=1.1p Rc=4.15K Vdd=4 Ibias=40u L1_2=3u L3_4=3u L5=1.75u L6=1.625u L7=3u L8=3u Vcm=2.5 W1_2=5.2e-05 W3_4=2e-06 W5=32.5u W6=4.4e-05 W7=0.00019 W8=45u
include "/lcars/home/e/ese6680/ami06.scs"

// ESE_6680/Current_Mirror/schematic
subckt Current_Mirror GND VDD out
    R0 (VDD out) resistor r=74.17K m=1
    M9 (out out GND GND) ami06N w=7.95u l=7.95u m=1 region=sat
    M10 (out out GND GND) ami06N w=24.0u l=1.5u m=1 region=sat
ends Current_Mirror

// ESE_6680/Current_Mirror_OPAMP/schematic
subckt Current_Mirror_OPAMP Gnd Output Vdd Vin\+ Vin\-
    M6 (Output net51 Gnd Gnd) ami06N w=W6 l=L6 m=1 region=sat
    M3 (net45 net45 Gnd Gnd) ami06N w=W3_4 l=L3_4 m=1 region=sat
    M4 (net51 net45 Gnd Gnd) ami06N w=W3_4 l=L3_4 m=1 region=sat
    Rc (net51 net55) resistor r=Rc m=1
    Cc (net55 Output) capacitor c=Cc m=1
    M7 (Output net44 Vdd Vdd) ami06P w=W7 l=L7 m=1 region=sat
    M8 (net44 net44 Vdd Vdd) ami06P w=W8 l=L8 m=1 region=sat
    M5 (net48 net44 Vdd Vdd) ami06P w=W5 l=L5 m=1 region=sat
    M1 (net45 Vin\- net48 net48) ami06P w=W1_2 l=L1_2 m=1 region=sat
    M2 (net51 Vin\+ net48 net48) ami06P w=W1_2 l=L1_2 m=1 region=sat
    I0 (Gnd Vdd net44) Current_Mirror
ends Current_Mirror_OPAMP

// ESE_6680/Current_Mirror_OPAMP_Test/schematic
C3 (Output1 0) capacitor c=2p m=1
C5 (Output3 0) capacitor c=2p m=1
C2 (Output4 0) capacitor c=2p m=1
C4 (Output2 0) capacitor c=2p m=1
V12 (net15 0) vsource type=dc dc=Vdd
V17 (net22 0) vsource type=dc dc=Vdd
V11 (net16 0) vsource type=dc dc=2.5 mag=500m
V10 (net29 0) vsource type=dc dc=2.5 mag=-500m
V14 (net28 0) vsource type=dc dc=2.5 mag=500m
V13 (net24 0) vsource type=dc dc=2.5 mag=500m
V16 (net21 0) vsource type=dc dc=Vdd
V15 (net14 0) vsource type=dc dc=Vdd
V8 (net23 0) vsource type=dc dc=Vcm mag=500m
V7 (net27 0) vsource type=dc dc=Vcm mag=-500m
V0 (net17 0) vsource type=pulse dc=2.5 mag=500m val0=0 val1=5 period=20u rise=1p fall=1p width=10u
I3 (0 Output2 net14 net17 Output2) Current_Mirror_OPAMP
I2 (0 Output4 net21 net23 net27) Current_Mirror_OPAMP
I1 (0 Output3 net22 net24 net28) Current_Mirror_OPAMP
I0 (0 Output1 net15 net16 net29) Current_Mirror_OPAMP
simulatorOptions options temp=27
ac ac start=10 stop=10G
tran tran stop=100u
dcOp dc
save V12:p
