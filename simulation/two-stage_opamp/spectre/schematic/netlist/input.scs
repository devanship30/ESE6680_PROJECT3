// Design: ESE_6680/two-stage_opamp
simulator lang=spectre
global 0 vdd!
include "/lcars/home/e/ese6680/ami06.scs"

// ESE_6680/two-stage_opamp/schematic
P4 (net2 net2 vdd! vdd!) ami06P w=40.05u l=1.2u m=1 region=sat
P3 (net010 net2 vdd! vdd!) ami06P w=229.95u l=1.2u m=1 region=sat
P2 (net6 net2 vdd! vdd!) ami06P w=40.05u l=1.2u m=1 region=sat
P1 (net7 net11 net6 net6) ami06P w=49.95u l=900n m=1 region=sat
P0 (net3 net014 net6 net6) ami06P w=49.95u l=900n m=1 region=sat
N2 (net010 net7 0 0) ami06N w=67.35u l=900n m=1 region=sat
N1 (net7 net3 0 0) ami06N w=8.7u l=900n m=1 region=sat
N0 (net3 net3 0 0) ami06N w=8.7u l=900n m=1 region=sat
I0 (net2 0) isource type=dc dc=20u m=1
R0 (net7 net18) resistor r=1K m=1
C1 (net010 0) capacitor c=2p m=1
C0 (net010 net18) capacitor c=1p m=1
V6 (net11 0) vsource type=dc dc=2.5 mag=500m
V5 (net014 0) vsource type=dc dc=2.5 mag=-500m
V0 (vdd! 0) vsource type=dc dc=5
simulatorOptions options temp=27
ac ac start=10 stop=100G dec=100
