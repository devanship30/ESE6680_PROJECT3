// Design: ESE6680_PROJECT3/ideal_8bit_dac
simulator lang=spectre
global 0
include "/lcars/home/e/ese6680/ami06.scs"

// ESE6680_PROJECT3/ideal_8bit_dac/schematic
I0 (VOUT1 VOUT2 VOUT3 VOUT4 VOUT5 VOUT6 VOUT7 VOUT8 net18 net19) adc_8bit_ideal
V2 (net18 0) vsource dc=2.5 type=sine ampl=1.5 freq=100K
V3 (net19 0) vsource type=pulse val0=0 val1=5 period=200n rise=10p fall=10p width=100n
I5 (VOUT8 VOUT7 VOUT6 VOUT5 VOUT4 VOUT3 VOUT2 VOUT1 vout) dac_8bit_ideal
simulatorOptions options temp=27
tran tran stop=20u
ahdl_include "/lcars/software/linux/x86_64/ic-design/cadence/IC618/tools/dfII/samples/artist/ahdlLib/adc_8bit_ideal/veriloga/veriloga.va"
ahdl_include "/lcars/software/linux/x86_64/ic-design/cadence/IC618/tools/dfII/samples/artist/ahdlLib/dac_8bit_ideal/veriloga/veriloga.va"
