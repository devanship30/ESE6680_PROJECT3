// Design: ese6680/Project3_MDAC_test
simulator lang=spectre
global 0
include "/lcars/home/e/ese6680/ami06.scs"

// ese6680/Project1_Opamp/schematic
subckt Project1_Opamp GND VDD Vin\+ Vin\- Vout
    M4 (net70 net66 GND GND) ami06N w=8.7u l=1.8u m=1 region=sat
    M3 (net66 net66 GND GND) ami06N w=8.7u l=1.8u m=1 region=sat
    M6 (Vout net70 GND GND) ami06N w=58.05u l=900n m=1 region=sat
    Cc (net80 Vout) capacitor c=1p m=1
    M7 (Vout net65 VDD VDD) ami06P w=133.95u l=1.2u m=1 region=sat
    M5 (net09 net65 VDD VDD) ami06P w=40.05u l=1.2u m=1 region=sat
    M8 (net65 net65 VDD VDD) ami06P w=40.05u l=1.2u m=1 region=sat
    M2 (net70 Vin\+ net09 VDD) ami06P w=49.95u l=1.8u m=1 region=sat
    M1 (net66 Vin\- net09 VDD) ami06P w=49.95u l=1.8u m=1 region=sat
    Iref (net65 GND) isource type=dc dc=60u m=1
    Rc (net70 net80) resistor r=1K m=1
ends Project1_Opamp

// ese6680/Project3_MDAC/schematic
subckt Project3_MDAC GND Phi1 Phi1E Phi2 VDD Vin\+ Vin\- Vout
    I0 (GND VDD net035 net2 Vout) Project1_Opamp
    Cs (net1 net2) capacitor c=2p m=1
    Cf (net2 net3) capacitor c=1p m=1
    N6 (iPhi2 Phi2 GND GND) ami06N w=1.5u l=600n m=1 region=sat
    N5 (iPhi1 Phi1 GND GND) ami06N w=1.5u l=600n m=1 region=sat
    N3 (Vin\+ Phi2 net1 GND) ami06N w=1.5u l=600n m=1 region=sat
    N4 (net1 Phi1 Vin\- GND) ami06N w=1.5u l=600n m=1 region=sat
    N0 (net2 Phi1E net037 GND) ami06N w=1.5u l=600n m=1 region=sat
    N1 (net027 Phi1 net3 GND) ami06N w=1.5u l=600n m=1 region=sat
    N2 (Vout Phi2 net3 GND) ami06N w=1.5u l=600n m=1 region=sat
    V2 (net027 GND) vsource type=dc dc=2.5
    V0 (net035 GND) vsource type=dc dc=2.5
    V1 (net037 GND) vsource type=dc dc=2.5
    P5 (iPhi2 Phi2 VDD VDD) ami06P w=1.5u l=600n m=1 region=sat
    P4 (iPhi1 Phi1 VDD VDD) ami06P w=1.5u l=600n m=1 region=sat
    P0 (net1 iPhi1 Vin\- VDD) ami06P w=1.5u l=600n m=1 region=sat
    P3 (Vin\+ iPhi2 net1 VDD) ami06P w=1.5u l=600n m=1 region=sat
    P2 (net027 iPhi1 net3 VDD) ami06P w=1.5u l=600n m=1 region=sat
    P1 (Vout iPhi2 net3 VDD) ami06P w=1.5u l=600n m=1 region=sat
ends Project3_MDAC

// ese6680/Project3_MDAC_test/schematic
I0 (0 Phi1 Phi1E Phi2 net3 Vin\+ Vin\- Vout) Project3_MDAC
V5 (Vin\- 0) vsource type=dc dc=2.5
V0 (net3 0) vsource type=dc dc=5
V4 (Vin\+ 0) vsource type=pulse val0=2 val1=3 period=1u rise=1n fall=1n width=500n
V3 (Phi1E 0) vsource type=pulse val0=0 val1=5 period=500n delay=0 rise=1n fall=1n width=200n
V2 (Phi2 0) vsource type=pulse val0=0 val1=5 period=500n delay=250n rise=1n fall=1n width=220n
V1 (Phi1 0) vsource type=pulse val0=0 val1=5 period=500n delay=0 rise=1n fall=1n width=220n
simulatorOptions options temp=27
tran tran stop=10u
save I0.V2:p I0.V2:p
