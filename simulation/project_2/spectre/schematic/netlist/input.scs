// Design: ESE_6680/project_2
simulator lang=spectre
global 0
include "/lcars/home/e/ese6680/ami06.scs"

// ESE_6680/project_2/schematic
N0 (Vin Clk Vout Vout) ami06N w=1.5u l=600n m=1 region=sat
C0 (Vout 0) capacitor c=1p m=1
V0 (Clk 0) vsource type=pulse dc=2.5 val0=0 val1=5 period=200n rise=1p fall=1p width=100n
V1 (Vin 0) vsource type=sine sinedc=2.5 ampl=1.5 freq=500.0K
simulatorOptions options temp=27
tran tran stop=10u
