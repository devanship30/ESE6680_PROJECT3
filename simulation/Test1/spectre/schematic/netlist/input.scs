// Design: ESE6680_PROJECT3/Test1
simulator lang=spectre
global 0
include "/lcars/home/e/ese6680/ami06.scs"

// ESE6680_PROJECT3/m_opamp/schematic
subckt m_opamp GND VDD Vin\+ Vin\- Vout
    M4 (net77 net74 GND GND) ami06N w=8.7u l=1.8u m=1 region=sat
    M3 (net74 net74 GND GND) ami06N w=8.7u l=1.8u m=1 region=sat
    M6 (Vout net77 GND GND) ami06N w=58.05u l=900n m=1 region=sat
    M7 (Vout net73 VDD VDD) ami06P w=133.95u l=1.2u m=1 region=sat
    M5 (net81 net73 VDD VDD) ami06P w=40.05u l=1.2u m=1 region=sat
    M8 (net73 net73 VDD VDD) ami06P w=40.05u l=1.2u m=1 region=sat
    M2 (net77 Vin\+ net81 VDD) ami06P w=49.95u l=1.8u m=1 region=sat
    M1 (net74 Vin\- net81 VDD) ami06P w=49.95u l=1.8u m=1 region=sat
    Iref (net73 GND) isource type=dc dc=60u m=1
    Cc (net84 Vout) capacitor c=1p m=1
    Rc (net77 net84) resistor r=1K m=1
ends m_opamp

// ESE6680_PROJECT3/Final_MDAC/schematic
subckt Final_MDAC GND Phi1 Phi1E Phi2 VDD Vin\+ Vin\- Vout
    N2 (Vout Phi2 net100 GND) ami06N w=1.5u l=600n m=1 region=sat
    N1 (net102 Phi1 net100 GND) ami06N w=1.5u l=600n m=1 region=sat
    N0 (net99 Phi1E net107 GND) ami06N w=1.5u l=600n m=1 region=sat
    N3 (Vin\+ Phi2 net97 GND) ami06N w=1.5u l=600n m=1 region=sat
    N4 (net97 Phi1 Vin\- GND) ami06N w=1.5u l=600n m=1 region=sat
    N6 (iPhi2 Phi2 GND GND) ami06N w=1.5u l=600n m=1 region=sat
    N5 (iPhi1 Phi1 GND GND) ami06N w=1.5u l=600n m=1 region=sat
    P1 (Vout iPhi2 net100 VDD) ami06P w=1.5u l=600n m=1 region=sat
    P2 (net102 iPhi1 net100 VDD) ami06P w=1.5u l=600n m=1 region=sat
    P0 (net97 iPhi1 Vin\- VDD) ami06P w=1.5u l=600n m=1 region=sat
    P3 (Vin\+ iPhi2 net97 VDD) ami06P w=1.5u l=600n m=1 region=sat
    P5 (iPhi2 Phi2 VDD VDD) ami06P w=1.5u l=600n m=1 region=sat
    P4 (iPhi1 Phi1 VDD VDD) ami06P w=1.5u l=600n m=1 region=sat
    Cf (net99 net100) capacitor c=1p m=1
    Cs (net97 net99) capacitor c=2p m=1
    V2 (net102 GND) vsource type=dc dc=2.5
    V0 (net106 GND) vsource type=dc dc=2.5
    V1 (net107 GND) vsource type=dc dc=2.5
    I0 (GND VDD net106 net99 Vout) m_opamp
ends Final_MDAC

// ESE6680_PROJECT3/inv/schematic
subckt inv IN OUT VDD
    N0 (OUT IN 0 0) ami06N w=1.5u l=600n m=1 region=sat
    P0 (OUT IN VDD VDD) ami06P w=3u l=600n m=1 region=sat
ends inv

// ESE6680_PROJECT3/buffer/schematic
subckt buffer IN OUT VDD
    I1 (net5 OUT VDD) inv
    I0 (IN net5 VDD) inv
ends buffer

// ESE6680_PROJECT3/nand/schematic
subckt nand A B OUT VDD
    N1 (net9 B 0 0) ami06N w=1.5u l=600n m=1 region=sat
    N0 (OUT A net9 0) ami06N w=1.5u l=600n m=1 region=sat
    P1 (OUT B VDD VDD) ami06P w=3u l=600n m=1 region=sat
    P0 (OUT A VDD VDD) ami06P w=3u l=600n m=1 region=sat
ends nand

// ESE6680_PROJECT3/non_overlapping_clock/schematic
subckt non_overlapping_clock CLK Phi1 Phi1E Phi2 VDD
    I205 (net26 Phi1 VDD) buffer
    I208 (net22 net23 VDD) buffer
    I203 (net35 net34 VDD) buffer
    I210 (net24 net13 VDD) buffer
    I207 (net21 net22 VDD) buffer
    I206 (net15 net20 VDD) buffer
    I209 (net23 net24 VDD) buffer
    I202 (net33 Phi1E VDD) buffer
    I204 (net27 net26 VDD) buffer
    I201 (net34 net33 VDD) buffer
    I214 (net16 net13 Phi2 VDD) nand
    I213 (net20 net12 net21 VDD) nand
    I198 (net12 net10 net27 VDD) nand
    I197 (CLK net16 net10 VDD) nand
    I215 (CLK net15 VDD) inv
    I212 (net25 net16 VDD) inv
    I211 (net13 net25 VDD) inv
    I200 (Phi1E net12 VDD) inv
    I199 (net10 net35 VDD) inv
ends non_overlapping_clock

// ESE6680_PROJECT3/Test1/schematic
I0 (0 Phi1 Phi1E Phi2 net09 Vin\+ Vin\- Vout) Final_MDAC
I3 (net013 Phi1 Phi1E Phi2 net09) non_overlapping_clock
V4 (Vin\- 0) vsource type=dc dc=2.8
V2 (net09 0) vsource type=dc dc=5
V1 (Vin\+ 0) vsource type=dc dc=3.25
V3 (net013 0) vsource type=pulse val0=0 val1=5 period=2u delay=0 rise=1n fall=1n width=900n
simulatorOptions options temp=27
tran tran stop=10u
