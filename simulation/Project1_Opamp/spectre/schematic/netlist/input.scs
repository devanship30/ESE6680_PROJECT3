// Design: ese6680/Project1_Opamp
simulator lang=spectre
global 0
include "/apps/design_kits/ncsu-cdk-1.6.0.beta/models/spectre/nom/ami06N.m"
include "/apps/design_kits/ncsu-cdk-1.6.0.beta/models/spectre/nom/ami06P.m"

// ese6680/Project1_Opamp/schematic
M4 (net70 net66 GND GND) ami06N w=8.7u l=1.8u m=1 region=sat
M3 (net66 net66 GND GND) ami06N w=8.7u l=1.8u m=1 region=sat
M6 (Vout net70 GND GND) ami06N w=58.05u l=900n m=1 region=sat
Cc (net80 Vout) capacitor c=1p m=1
CL (Vout GND) capacitor c=2p m=1
M7 (Vout net65 VDD VDD) ami06P w=133.95u l=1.2u m=1 region=sat
M5 (net69 net65 VDD VDD) ami06P w=40.05u l=1.2u m=1 region=sat
M8 (net65 net65 VDD VDD) ami06P w=40.05u l=1.2u m=1 region=sat
M2 (net70 Vin\+ net69 net69) ami06P w=49.95u l=1.8u m=1 region=sat
M1 (net66 Vin\- net69 net69) ami06P w=49.95u l=1.8u m=1 region=sat
Iref (net65 GND) isource type=dc dc=60u m=1
Rc (net70 net80) resistor r=1K m=1
simulatorOptions options temp=27
dcOp dc
