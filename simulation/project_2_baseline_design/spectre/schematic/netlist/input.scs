// Design: ESE_6680/project_2_baseline_design
simulator lang=spectre
global 0
parameters Cf=1.35p Ch=1.35p L10=0.6u L11=0.6u L12=0.6u L13=0.6u L14=0.6u L9=0.6u W10=45u W11=3.5u W12=5u W13=6.5u W14=7.5u W9=5u
include "/lcars/home/e/ese6680/ami06.scs"

// ESE_6680/opamp_project_1/schematic
subckt opamp_project_1 Gnd Output Vdd Vin\+ Vin\-
    M6 (Output net55 Gnd Gnd) ami06N w=60u l=1.65u m=1 region=sat
    M3 (net49 net49 Gnd Gnd) ami06N w=16.5u l=3u m=1 region=sat
    M4 (net55 net49 Gnd Gnd) ami06N w=16.5u l=3u m=1 region=sat
    Rc (net55 net59) resistor r=4.15K m=1
    Cc (net59 Output) capacitor c=1.1p m=1
    M7 (Output net48 Vdd Vdd) ami06P w=268.05u l=3u m=1 region=sat
    M8 (net48 net48 Vdd Vdd) ami06P w=43.95u l=3u m=1 region=sat
    M5 (net52 net48 Vdd Vdd) ami06P w=37.05u l=1.8u m=1 region=sat
    M1 (net49 Vin\- net52 net52) ami06P w=115.05u l=3u m=1 region=sat
    M2 (net55 Vin\+ net52 net52) ami06P w=115.05u l=3u m=1 region=sat
    I13 (net48 Gnd) isource type=dc dc=40u m=1
ends opamp_project_1

// ESE_6680/project_2_baseline_design/schematic
N2 (net016 CLK1 Output 0) ami06N w=W13 l=L13 m=1 region=sat
N0 (Vin CLK1 net02 0) ami06N w=W9 l=L9 m=1 region=sat
N1 (net02 CLK2 net019 0) ami06N w=W11 l=L11 m=1 region=sat
C7 (net02 net016) capacitor c=Ch m=1
C3 (Output 0) capacitor c=1p m=1
C8 (net016 Output) capacitor c=Cf m=1
V6 (Vin 0) vsource type=sine sinedc=2.5 ampl=1.5 freq=500K
V10 (CLK1 0) vsource type=pulse dc=2.5 val0=0 val1=5 period=200n delay=0 rise=200.0p fall=200.0p width=90n
V11 (CLK2 0) vsource type=pulse dc=2.5 val0=0 val1=5 period=200n delay=100n rise=200.0p fall=200.0p width=90n
V12 (CLK2\' 0) vsource type=pulse dc=2.5 val0=5 val1=0 period=200n delay=100n rise=200.0p fall=200.0p width=90n
V13 (CLK1\' 0) vsource type=pulse dc=2.5 val0=5 val1=0 period=200n delay=0 rise=200.0p fall=200.0p width=90n
I38 (0 Output VDD net05 net016) opamp_project_1
V8 (net019 0) vsource type=dc dc=2.5
V9 (net05 0) vsource type=dc dc=2.5
V0 (VDD 0) vsource type=dc dc=5
P2 (net02 CLK2\' net019 VDD) ami06P w=W12 l=L12 m=1 region=sat
P0 (Output CLK1\' net016 VDD) ami06P w=W14 l=L14 m=1 region=sat
P1 (net02 CLK1\' Vin VDD) ami06P w=W10 l=L10 m=1 region=sat
simulatorOptions options temp=27
tran tran stop=10u
save V0:p
