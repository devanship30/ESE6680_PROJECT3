// Design: ese6680/Project1_Test
simulator lang=spectre
global 0
parameters vac=1 vdc=2.5
include "/lcars/home/e/ese6680/ami06.scs"

// ese6680/Project1_Opamp/schematic
subckt Project1_Opamp GND VDD Vin\+ Vin\- Vout
    M4 (net70 net66 GND GND) ami06N w=8.7u l=1.8u m=1 region=sat
    M3 (net66 net66 GND GND) ami06N w=8.7u l=1.8u m=1 region=sat
    M6 (Vout net70 GND GND) ami06N w=58.05u l=900n m=1 region=sat
    Cc (net80 Vout) capacitor c=1p m=1
    CL (Vout GND) capacitor c=2p m=1
    M7 (Vout net65 VDD VDD) ami06P w=133.95u l=1.2u m=1 region=sat
    M5 (net09 net65 VDD VDD) ami06P w=40.05u l=1.2u m=1 region=sat
    M8 (net65 net65 VDD VDD) ami06P w=40.05u l=1.2u m=1 region=sat
    M2 (net70 Vin\+ net09 VDD) ami06P w=49.95u l=1.8u m=1 region=sat
    M1 (net66 Vin\- net09 VDD) ami06P w=49.95u l=1.8u m=1 region=sat
    Iref (net65 GND) isource type=dc dc=60u m=1
    Rc (net70 net80) resistor r=1K m=1
ends Project1_Opamp

// ese6680/Project1_Test/schematic
I9 (0 net4 net1 net2 net3) Project1_Opamp
V2 (net1 0) vsource type=dc dc=2.5 mag=500.0m
V1 (net2 0) vsource type=dc dc=2.5 mag=-500m
V0 (net4 0) vsource type=dc dc=5
simulatorOptions options temp=27
dcOp dc
ac ac start=10 stop=100G dec=100
