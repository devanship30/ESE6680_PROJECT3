// Design: ese6680/Project2_Test_Dynamic
simulator lang=spectre
global 0
parameters vd=0.079
include "/lcars/home/e/ese6680/ami06.scs"

// ese6680/Project2_Dynamic/schematic
subckt Project2_Dynamic Clk Gnd Vdd Vin_n Vin_p out_m out_p
    P4 (out_p out_m net25 Vdd) ami06P w=1.5u l=600n m=1 region=sat
    P3 (out_m out_p net27 Vdd) ami06P w=1.5u l=600n m=1 region=sat
    P2 (net25 Vin_p net22 Vdd) ami06P w=1.65u l=600n m=1 region=sat
    P1 (net27 Vin_n net22 Vdd) ami06P w=1.5u l=600n m=1 region=sat
    P5 (net22 Clk Vdd Vdd) ami06P w=1.5u l=600n m=1 region=sat
    N5 (net25 Clk Gnd Gnd) ami06N w=1.5u l=600n m=1 region=sat
    N4 (out_p Clk Gnd Gnd) ami06N w=1.5u l=600n m=1 region=sat
    N3 (out_p out_m Gnd Gnd) ami06N w=1.5u l=600n m=1 region=sat
    N2 (out_m out_p Gnd Gnd) ami06N w=1.5u l=600n m=1 region=sat
    N1 (out_m Clk Gnd Gnd) ami06N w=1.5u l=600n m=1 region=sat
    N0 (net27 Clk Gnd Gnd) ami06N w=1.5u l=600n m=1 region=sat
ends Project2_Dynamic

// ese6680/Project2_Test_Dynamic/schematic
I0 (net2 0 net1 net4 net5 out_m out_p) Project2_Dynamic
V2 (net4 0) vsource type=dc dc=2.5 - vd/2
V1 (net5 0) vsource type=dc dc=2.5 + vd/2
V0 (net1 0) vsource type=dc dc=5
V3 (net2 0) vsource type=pulse val0=0 val1=5 period=2u delay=0 rise=200.0p fall=200.0p width=1u
simulatorOptions options temp=27
tran tran stop=2000n
