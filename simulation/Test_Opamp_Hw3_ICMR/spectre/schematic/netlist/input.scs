// Design: ese6680/Test_Opamp_Hw3_ICMR
simulator lang=spectre
global 0
parameters Cc=1p Vcm=1 w=40u
include "/lcars/home/e/ese6680/ami06.scs"

// ese6680/hw3_2stage_opamp/schematic
subckt hw3_2stage_opamp GND VDD Vin\+ Vin\- Vout
    M2 (net11 Vin\+ net09 VDD) ami06P w=109.95u l=3u m=1 region=sat
    M1 (net3 Vin\- net09 VDD) ami06P w=109.95u l=3u m=1 region=sat
    M7 (Vout net019 VDD VDD) ami06P w=268.05u l=2.4u m=1 region=sat
    M5 (net09 net019 VDD VDD) ami06P w=36.6u l=1.2u m=1 region=sat
    M8 (net019 net019 VDD VDD) ami06P w=40.05u l=1.2u m=1 region=sat
    M6 (Vout net11 GND GND) ami06N w=55.05u l=1.8u m=1 region=sat
    M4 (net11 net3 GND GND) ami06N w=17.55u l=3u m=1 region=sat
    M3 (net3 net3 GND GND) ami06N w=17.55u l=3u m=1 region=sat
    C1 (net22 Vout) capacitor c=1p m=1
    C0 (Vout GND) capacitor c=2p m=1
    RC (net11 net22) resistor r=1.2K m=1
    I0 (net019 GND) isource type=dc dc=60u m=1
ends hw3_2stage_opamp

// ese6680/Test_Opamp_Hw3_ICMR/schematic
V1 (net3 0) vsource type=dc dc=5
V0 (net1 0) vsource type=dc dc=Vcm mag=500.0m
V2 (net2 0) vsource type=dc dc=Vcm mag=-500m
I0 (0 net3 net1 net2 Vout) hw3_2stage_opamp
simulatorOptions options temp=27
ac ac freq=10 param=Vcm start=0 stop=5 lin=10000
