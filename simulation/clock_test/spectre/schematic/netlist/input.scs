// Design: ESE6680_PROJECT3/clock_test
simulator lang=spectre
global 0
include "/lcars/home/e/ese6680/ami06.scs"

// ESE6680_PROJECT3/inv/schematic
subckt inv IN OUT VDD
    N0 (OUT IN 0 0) ami06N w=1.5u l=600n m=1 region=sat
    P0 (OUT IN VDD VDD) ami06P w=3u l=600n m=1 region=sat
ends inv

// ESE6680_PROJECT3/buffer/schematic
subckt buffer IN OUT VDD
    I1 (net5 OUT VDD) inv
    I0 (IN net5 VDD) inv
ends buffer

// ESE6680_PROJECT3/nand/schematic
subckt nand A B OUT VDD
    N1 (net9 B 0 0) ami06N w=1.5u l=600n m=1 region=sat
    N0 (OUT A net9 0) ami06N w=1.5u l=600n m=1 region=sat
    P1 (OUT B VDD VDD) ami06P w=3u l=600n m=1 region=sat
    P0 (OUT A VDD VDD) ami06P w=3u l=600n m=1 region=sat
ends nand

// ESE6680_PROJECT3/non_overlapping_clock/schematic
subckt non_overlapping_clock CLK Phi1 Phi1E Phi2 VDD phi1\' phi2\'
    I218 (net037 phi2\' VDD) buffer
    I217 (net036 net037 VDD) buffer
    I220 (net039 net038 VDD) buffer
    I221 (net038 phi1\' VDD) buffer
    I205 (net26 Phi1 VDD) buffer
    I208 (net22 net23 VDD) buffer
    I203 (net35 net34 VDD) buffer
    I210 (net24 net13 VDD) buffer
    I207 (net21 net22 VDD) buffer
    I206 (net15 net20 VDD) buffer
    I209 (net23 net24 VDD) buffer
    I202 (net33 Phi1E VDD) buffer
    I204 (net27 net26 VDD) buffer
    I201 (net34 net33 VDD) buffer
    I214 (net16 net13 Phi2 VDD) nand
    I213 (net20 net12 net21 VDD) nand
    I198 (net12 net10 net27 VDD) nand
    I197 (CLK net16 net10 VDD) nand
    I215 (CLK net15 VDD) inv
    I212 (net025 net16 VDD) inv
    I211 (net13 net025 VDD) inv
    I216 (Phi2 net036 VDD) inv
    I219 (Phi1 net039 VDD) inv
    I200 (Phi1E net12 VDD) inv
    I199 (net10 net35 VDD) inv
ends non_overlapping_clock

// ESE6680_PROJECT3/clock_test/schematic
I0 (CLK phi1 phi1E phi2 VDD phi1\' phi2\') non_overlapping_clock
V0 (VDD 0) vsource type=dc dc=5
V1 (CLK 0) vsource type=pulse val0=0 val1=5 period=200n rise=10p fall=10p width=90n
simulatorOptions options temp=27
tran tran stop=5u
