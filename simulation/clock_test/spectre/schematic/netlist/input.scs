// Design: ESE6680_PROJECT3/clock_test
simulator lang=spectre
global 0
include "/lcars/home/e/ese6680/ami06.scs"

// ESE6680_PROJECT3/inv/schematic
subckt inv IN OUT VDD
    N0 (OUT IN 0 0) ami06N w=1.5u l=600n m=1 region=sat
    P0 (OUT IN VDD VDD) ami06P w=3u l=600n m=1 region=sat
ends inv

// ESE6680_PROJECT3/buffer/schematic
subckt buffer IN OUT VDD
    I1 (net5 OUT VDD) inv
    I0 (IN net5 VDD) inv
ends buffer

// ESE6680_PROJECT3/nand/schematic
subckt nand A B OUT VDD
    N1 (net9 B 0 0) ami06N w=1.5u l=600n m=1 region=sat
    N0 (OUT A net9 0) ami06N w=1.5u l=600n m=1 region=sat
    P1 (OUT B VDD VDD) ami06P w=3u l=600n m=1 region=sat
    P0 (OUT A VDD VDD) ami06P w=3u l=600n m=1 region=sat
ends nand

// ESE6680_PROJECT3/non_overlapping_clock/schematic
subckt non_overlapping_clock CLK Phi1 Phi1E Phi2 VDD
    I25 (net028 Phi1 VDD) inv
    I27 (net051 Phi2 VDD) inv
    I159 (CLK net039 VDD) inv
    I29 (Phi1E net011 VDD) inv
    I17 (net010 net013 VDD) inv
    I28 (net029 net022 VDD) inv
    I14 (net039 net049 VDD) inv
    I155 (net035 net017 VDD) inv
    I176 (net037 Phi1E VDD) buffer
    I164 (net030 net029 VDD) buffer
    I175 (net013 net037 VDD) buffer
    I163 (net017 net030 VDD) buffer
    I83 (net022 net022 net051 VDD) nand
    I82 (net011 net011 net028 VDD) nand
    I15 (net039 net035 net010 VDD) nand
    I16 (net049 net010 net035 VDD) nand
ends non_overlapping_clock

// ESE6680_PROJECT3/clock_test/schematic
I0 (CLK Phi1 Phi1E Phi2 VDD) non_overlapping_clock
V0 (VDD 0) vsource type=dc dc=5
V1 (CLK 0) vsource type=pulse val0=0 val1=5 period=200n rise=10p fall=10p width=90n
simulatorOptions options temp=27
tran tran stop=5u
