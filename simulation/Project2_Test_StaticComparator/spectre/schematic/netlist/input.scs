// Design: ese6680/Project2_Test_StaticComparator
simulator lang=spectre
global 0
include "/lcars/home/e/ese6680/ami06.scs"

// ese6680/Project2_StaticComparator/schematic
subckt Project2_StaticComparator Gnd STROBE Vdd Vi1 Vi2 Vo1 Vo2
    P3 (Vo2 STROBE Vo1 Vdd) ami06P w=3u l=600n m=1 region=sat
    P2 (Vo1 STROBE Vo2 Vdd) ami06P w=3u l=600n m=1 region=sat
    P1 (Vo2 Vo1 Vdd Vdd) ami06P w=12.0u l=600n m=1 region=sat
    P0 (Vo1 Vo2 Vdd Vdd) ami06P w=12.0u l=600n m=1 region=sat
    N1 (Vo1 Vi2 net15 Gnd) ami06N w=12.0u l=600n m=1 region=sat
    N0 (Vo2 Vi1 net15 Gnd) ami06N w=12.0u l=600n m=1 region=sat
    I0 (net15 Gnd) isource type=dc dc=30u m=1
ends Project2_StaticComparator

// ese6680/Project2_Test_StaticComparator/schematic
I7 (0 net05 net1 net03 net04 Vo1 Vo2) Project2_StaticComparator
V2 (net04 0) vsource type=dc dc=2.495
V1 (net03 0) vsource type=dc dc=2.505
V0 (net1 0) vsource type=dc dc=5
V3 (net05 0) vsource type=pulse val0=0 val1=5 period=100n delay=5n rise=200.0p fall=200.0p width=45n
simulatorOptions options temp=27
tran tran stop=200n
save net05 Vo1 Vo2
